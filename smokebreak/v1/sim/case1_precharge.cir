* SmokeBreak v1 - Case 1: pre-charge through RPRE, then main switch close
* Board per src/circuit.py (TPS48000, low-side shunt). Battery -> board ->
* 10 cm leads -> drone: ESC bulk + constant-power VTX (UVLO 6 V) + FC/RX 1 W.
* t=0..0.5 ms: pack EMF ramps up (soft start). t=1 ms: QP on (PRE_ON high).  t=tmain: INP high.  t=tpoff: QP off.
* Gate network: PU resistor rpu, optional Cdvdt c1 (gate->GND via 10 Ohm).
* Run from sim/:  ngspice -b case1_precharge.cir
.include lib/smokebreak.lib
.include lib/board.lib

.param ncell=14 vcell=4.35 rpre=7.8 cload=2200u esr=30m pvtx=15
.param tmain=2 tpoff=2 rpu=47 c1=1p qp_rd=0.15 qp_kp=6 tstop=1.0 tmax=200u
.param vb={ncell*vcell}

XB vin gnd BATTR ncell={ncell} vcell={vcell} rcell=3m lser=250n rlead=3m tramp=0.5m
Rg0 gnd 0 1u
V33 v33 gnd 3.3
XPP vin src gate vout gnd dneg inp scp PPATH rpu={rpu} c1={c1}
XPR vin vout gnd preon guard PRECH rpre={rpre} qp_rd={qp_rd} qp_kp={qp_kp}
XAX vin vout gnd aux v33 vlo AUXSENSE
Vguard guard gnd 3.3
Vpre preon gnd PWL(0 0 1m 0 1.01m 3.3 {tpoff} 3.3 {tpoff+10u} 0)
Vinp inp gnd PWL(0 0 {tmain} 0 {tmain+1u} 3.3)

* drone: leads (2 x 10 cm) + bulk + VTX + FC, returning to DRONE_NEG
Lol vout d1 100n
Rol d1 drn 2m
Lon dneg dn1 100n
Ron dn1 drnn 2m
XBK drn drnn BULK c={cload} esr={esr}
XVTX drn drnn CPLOAD pw={pvtx} vuv=6
XFC drn drnn CPLOAD pw=1 vuv=3.2

.options method=gear reltol=1e-3 abstol=1e-6 vntol=1e-4 chgtol=1e-12 itl4=300

.tran 10u {tstop} 0 {tmax} uic
.control
set wr_singlescale
set wr_vecnames
option numdgt=7
run
let ipre = i(v.xpr.vipre)
let ppre = ipre*v(xpr.pkx,vout)
let pqp = v(vin,xpr.qd)*i(v.xpr.vqp)
let pd3 = v(xpr.qd,xpr.pk)*ipre
let iq1 = i(v.xpp.vq1)
let pq1 = v(vin,src)*i(v.xpp.vq1)
let pq2 = v(vout,src)*i(v.xpp.vq2)
let vgs = v(gate,src)
let vds1 = v(vin,src)
wrdata work/c1.dat v(vin) v(vout) v(drn) ipre ppre iq1 pq1 pq2 vgs v(src) pqp pd3 vds1 v(scp)
.endc
.end
