* SmokeBreak v1 - Case 1: pre-charge through RPRE, then main switch close
* Battery -> board (PPATH + PRECH + AUXSENSE) -> 10 cm drone leads -> ESC bulk
* + constant-power digital VTX (UVLO 6 V) + FC/RX idle (1 W, UVLO 3.2 V).
* t=0: QP on.  t=tmain: INP high (slow gate, C1).  t=tpoff: QP off.
* Run from sim/:  ngspice -b case1_precharge.cir
.include lib/smokebreak.lib
.include lib/board.lib

.param ncell=14 vcell=3.85 rpre=6.8 cload=0.0022 esr=30m pvtx=15
.param tmain=2.0 tpoff=2.0 c1=1.5e-07 tstop=1.0 tmax=0.0002

* battery (good cells), already connected
XB vin pg BATT ncell={ncell} vcell={vcell} rcell=3m lser=250n rlead=3m
Rgnd pg 0 1u
Rlg lgnd pg 1m

XPP vin vsh src gate vout pg lgnd inp scp PPATH c1={c1}
XPR vin vout lgnd pen PRECH rpre={rpre}
XAX vin vout lgnd aux AUXSENSE

* control
Vpen pen lgnd PWL(0 0 10u 3.3 {tpoff} 3.3 {tpoff+10u} 0)
Vinp inp lgnd PWL(0 0 {tmain} 0 {tmain+1u} 3.3)

* drone: leads (2 x 10 cm 14 AWG) + bulk + VTX + FC
Lol vout d1 100n
Rol d1 drn 2m
XBK drn pg BULK c={cload} esr={esr}
XVTX drn pg CPLOAD pw={pvtx} vuv=6
XFC drn pg CPLOAD pw=1 vuv=3.2

.options method=gear reltol=1e-3 abstol=1e-8 vntol=1e-5 itl4=200 klu
.ic v(vout)=0 v(drn)=0 v(src)=0 v(gate)=0 v(xpp.bst)=12.3
.tran 10u {tstop} 0 {tmax} uic
.control
set wr_singlescale
set wr_vecnames
option numdgt=7
run
let ipre = i(v.xpr.vipre)
let ppre = ipre*v(xpr.rp,vout)
let iq1 = i(v.xpp.vq1)
let pq1 = v(vsh,src)*i(v.xpp.vq1)
let pq2 = v(vout,src)*i(v.xpp.vq2)
let vgs = v(gate,src)
wrdata work/c1a_6.8_14_3.85.dat v(vin) v(vout) v(drn) ipre ppre iq1 pq1 pq2 vgs v(src)
.endc
.end
