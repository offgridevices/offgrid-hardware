* TPS alone
.include work/sb_t.lib
Vvs vs 0 17
Vinp inp 0 PWL(0 0 1m 0 1.001m 3.3)
XC vs 0 inp vs vsh src pu pd bst scp TPS48111
Rsh vs vsh 1m
Cbst bst src 2.2u
Rsrc src 0 10k
R1 pu g 100k
Rpd pd g 0.1
Cg g 0 150n
.options method=gear
.ic v(bst)=12 v(src)=0
.tran 1u 5m 0 10u uic
.control
run
print v(g)[length(v(g))-1] v(bst,src)[length(v(g))-1]
.endc
.end
