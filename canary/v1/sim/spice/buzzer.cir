* Canary v1 sounder driver: CMT-8504 magnetic transducer from VBUS,
* AO3400A low-side switch, B5819W clamp, 4 kHz 50 % drive from PB1 (3.3 V).
* USB source: 5.0 V behind 1 m of cable (~0.15 ohm, ~0.8 uH round trip).
* Coil: 15 ohm (datasheet), inductance not specified -> swept (LCOIL).
.param LCOIL=2m
VUSB usb 0 5.0
RCAB usb n1 0.15
LCAB n1 vbus 0.8u
* C1 + C13 bulk on VBUS (10 uF X5R each, ~50 % left at 5 V bias), ESR 5 mohm
C1 vbus c1 5u
RC1 c1 0 5m
C13 vbus c13 5u
RC13 c13 0 5m
* transducer: R + L in series
RCOIL vbus nc 15
LCOIL1 nc buzd {LCOIL}
* clamp B5819W: anode at drain, cathode at VBUS
D2 buzd d2k B5819W
VD2 d2k vbus 0
.model B5819W D(Is=31.7u N=1.373 Rs=0.051 Cjo=110p M=0.38 Vj=0.35 BV=40 Ibv=1m)
* AO3400A (VDMOS approximation from datasheet: Vth 1.05 V typ, Rds(on) 33 mohm @4.5 V, Ciss 630 pF)
M1 buzd g 0 0 AO3400A
.model AO3400A VDMOS(Vto=1.05 Kp=40 Rd=8m Rs=8m Rg=1.5 Cgdmax=150p Cgdmin=20p Cgs=550p Cjo=100p Is=1e-11 Rb=10m mtriode=1.3 lambda=0.01)
* MCU pin (3.3 V, ~25 ohm driver) -> R9 100 ohm -> gate; R10 100k pull-down
VPB1 pb1 0 PULSE(0 3.3 0 20n 20n 125u 250u)
RDRV pb1 pb1r 25
R9 pb1r g 100
R10 g 0 100k
.tran 0.1u 3m 0 0.05u
.control
run
meas tran vds_peak MAX v(buzd) from=1m to=3m
meas tran icoil_peak MAX i(VD2) from=1m to=3m
meas tran isrc_peak MIN i(VUSB) from=1m to=3m
meas tran vbus_min MIN v(vbus) from=1m to=3m
meas tran iavg AVG i(VUSB) from=1m to=3m
meas tran id2_peak MAX i(VD2) from=1m to=3m
meas tran vgs_hi MAX v(g) from=1m to=3m
echo RESULT $&vds_peak $&isrc_peak $&vbus_min $&iavg $&id2_peak $&vgs_hi > result.txt
wrdata wave.txt v(buzd) v(vbus) v(g) i(VD2)
quit
.endc
.end
